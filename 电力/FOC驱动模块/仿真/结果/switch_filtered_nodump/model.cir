* FOC power stage behavior model: switch_filtered_nodump
* Generated by simulate_power_stage.py. No manufacturer MOS macro is used.
* Six switch states, 3 low-side shunts, DC-link C/ESR/ESL, source R/L,
* parameterized sinusoidal motor back-EMF and phase R/L, local OVP/OCP latch,
* and a hysteretic local brake chopper. Fixed-speed EMF is a mechanical energy
* reservoir; the electrical source is one-way and cannot silently absorb regen.
.title switch_filtered_nodump
.options method=gear reltol=0.001 abstol=1u vntol=1u maxord=2
.param PI=3.14159265358979 VDC=32.4 FSW=20000 FE=700
.param EPK=12.830005982 IPK=-109.38457474 RPH=0.017 LPH=2e-05
.param RDSON=0.005 RSH=0.0005 TD=5e-07
.param WEDGE=0.01 DTDU=0.04
.param CLOCAL=0.03 ESRLOCAL=0.006333 ESLLOCAL=1.5e-08
.param RSRC=0.01 LSRC=1e-06
.param TSTART=0.0002 TEND=0.002
.param TARM=2e-06
.param RAMP=0.00015
.param VCORE=5 VSAFE=4.9764817276
.param DUMPEN=1
.param TVSEN=0 TVSBRMAX=49.1 TVSRD=0.644
.param RDUMP=2

* Battery/source Thevenin R-L. Dsrc blocks reverse/regen acceptance in this
* first baseline profile. Source current is explicitly measured at Vsense.
Vbattery batt 0 {VDC}
Vsense batt src1 0
Rsource src1 src2 {RSRC}
Lsource src2 src3 {LSRC} IC=0
Dsrc src3 bus D_SOURCE
.model D_SOURCE D(IS=1e-9 N=1.2 RS=2m CJO=500p TT=200n)

* Local DC-link bank, not remote module capacitance. ESR/ESL are lumped.
Llink bus cap_esr {ESLLOCAL} IC=0
Resr cap_esr cap_i {ESRLOCAL}
Cbulk cap_i 0 {CLOCAL} IC={VDC}
* Three phase-leg near-bridge capacitors: each branch models one biased
* 4.7uF (2.35uF effective) plus one 100nF ceramic, including ESR/ESL.
LhfA bus hfA_esr 1e-09 IC=0
RhfA hfA_esr hfA_cap 0.005
ChfA hfA_cap 0 2.45e-06 IC={VDC}
LhfB bus hfB_esr 1e-09 IC=0
RhfB hfB_esr hfB_cap 0.005
ChfB hfB_cap 0 2.45e-06 IC={VDC}
LhfC bus hfC_esr 1e-09 IC=0
RhfC hfC_esr hfC_cap 0.005
ChfC hfC_cap 0 2.45e-06 IC={VDC}
Rbus_ff bus bus_ff 100
Cbus_ff bus_ff 0 1e-06 IC={VDC}

* Optional finite-slope SMCJ40A behavior branch; ST DS1284 Rev 11 Table 2:
* VBR max 49.1 V, VCL max 64.5 V at 24 A, RD max 0.644 ohm.
Vtvs_sense bus bus_tvs 0
Btvs bus_tvs 0 I={ (TVSEN>0.5 && v(bus_tvs)>TVSBRMAX) ? (v(bus_tvs)-TVSBRMAX)/TVSRD : 0 }

* 0-V measurement source separates inverter DC power from source/cable power.
Vbus_sense bus bus_inv 0

* Local brake chopper: resistor-programmed open-collector comparator, an
* independent SAFE_5V rail, gate driver, Q7 and 2x 2-ohm pulse resistors.
Vcore5 core5 0 {VCORE}
Vsafe5 safe5 0 {VSAFE}
Rovtop bus ov_sense 162k
Rovbot ov_sense 0 10k
Rref_top safe5 ov_ref 10.2k
Rref_bot ov_ref 0 10k
Rhyst busov_n ov_ref 200k
Rov_pullup safe5 busov_n 4.7k
* Full-temperature VOL boundary; behavior-level comparator has no propagation delay.
Boc busov_n 0 I={ (v(ov_sense)>v(ov_ref)) ? (v(busov_n)-0.9)/5 : 0 }
Ccmp busov_n 0 100p IC=4.92017398333
Covsense ov_sense 0 1e-09
Bdrv drv_cmd 0 V={ ((DUMPEN>0.5) && (v(safe5)>4.5) && (v(busov_n)<1.0)) ? 5 : 0 }
Rgate drv_cmd brkgate 10
Cgate brkgate 0 1e-08
Rgate_pd brkgate 0 10k
RdumpA bus dump_bus {RDUMP}
RdumpB bus dump_bus {RDUMP}
Ldump dump_bus dump_sw 10n
Sbrake dump_sw 0 brkgate 0 SW_DUMP
.model SW_DUMP SW(Ron=11.25m Roff=1G Vt=2.5 Vh=0.1)

* PWM carrier and sinusoidal references. Min-max zero-sequence injection is
* space-vector modulation in the linear range; no rotor estimator or firmware.
Btri tri 0 V={0.5+asin(sin(2*pi*FSW*time))/pi}
Bamp amp 0 V={ ((time<TSTART) || (time>TEND)) ? 0 : (((time<(TSTART+RAMP)) ? IPK*(time-TSTART)/RAMP : ((time>(TEND-RAMP)) ? IPK*(TEND-time)/RAMP : IPK))) }
Btheta theta 0 V={2*pi*FE*time}
BvA vA 0 V={EPK*sin(v(theta)) + RPH*v(amp)*sin(v(theta)) + LPH*(2*pi*FE)*v(amp)*cos(v(theta))}
BvB vB 0 V={EPK*sin(v(theta)-2*pi/3) + RPH*v(amp)*sin(v(theta)-2*pi/3) + LPH*(2*pi*FE)*v(amp)*cos(v(theta)-2*pi/3)}
BvC vC 0 V={EPK*sin(v(theta)+2*pi/3) + RPH*v(amp)*sin(v(theta)+2*pi/3) + LPH*(2*pi*FE)*v(amp)*cos(v(theta)+2*pi/3)}
BvMax vMax 0 V={ (v(vA)>v(vB)) ? ((v(vA)>v(vC)) ? v(vA) : v(vC)) : ((v(vB)>v(vC)) ? v(vB) : v(vC)) }
BvMin vMin 0 V={ (v(vA)<v(vB)) ? ((v(vA)<v(vC)) ? v(vA) : v(vC)) : ((v(vB)<v(vC)) ? v(vB) : v(vC)) }
BvCM vCM 0 V={-0.5*(v(vMax)+v(vMin))}
Barm arm 0 V={ (time<TSTART) ? 0 : ((time>TSTART+TARM) ? 1 : (time-TSTART)/TARM) }
BrawDA rawDA 0 V={0.5+(v(vA)+v(vCM))/((v(bus_ff)>5)?v(bus_ff):5)}
BrawDB rawDB 0 V={0.5+(v(vB)+v(vCM))/((v(bus_ff)>5)?v(bus_ff):5)}
BrawDC rawDC 0 V={0.5+(v(vC)+v(vCM))/((v(bus_ff)>5)?v(bus_ff):5)}
BdutyA dutyA 0 V={(v(rawDA)<0.02)?0.02:((v(rawDA)>0.98)?0.98:v(rawDA))}
BdutyB dutyB 0 V={(v(rawDB)<0.02)?0.02:((v(rawDB)>0.98)?0.98:v(rawDB))}
BdutyC dutyC 0 V={(v(rawDC)<0.02)?0.02:((v(rawDC)>0.98)?0.98:v(rawDC))}

* Candidate low-side shunt trip +/-75mV (= +/-150A at 0.5mohm), after a
* simplified 0.5us first-order CSA/filter response. Shunt voltage is only
* present when current physically flows through the shunt, including diode.
BshA shA_src 0 V={v(nsA)}
RshfA shA_src shA_f 10k
CshfA shA_f 0 50p IC=0
BshB shB_src 0 V={v(nsB)}
RshfB shB_src shB_f 10k
CshfB shB_f 0 50p IC=0
BshC shC_src 0 V={v(nsC)}
RshfC shC_src shC_f 10k
CshfC shC_f 0 50p IC=0
Bfault_set fault 0 I={ ((abs(v(shA_f))>75m) || (abs(v(shB_f))>75m) || (abs(v(shC_f))>75m)) ? -1m : 0 }
Bfault_ov fault 0 I={ ((v(safe5)>4.5) && (v(busov_n)<1.0)) ? -1m : 0 }
Cfault fault 0 1n IC=0
Rfault fault 0 100G
Bfault_clamp fault 0 I={ (v(fault)>3.3) ? (v(fault)-3.3)/1 : 0 }

* Each MOSFET is a datasheet-parameterized behavioral channel (hot RDS(on)),
* plus a built-in diode and fixed Coss; no vendor MOS macro is used.
* PWL body diodes (0.7V + 20mohm) avoid an unqualified vendor diode macro.

* Phase A half bridge and 0.5-milliohm low-side shunt.
BghA ghA 0 V={ ((v(fault)<1.5 && v(core5)>4.5) ? 10*v(arm)*((v(tri)<v(dutyA)-WEDGE)?1:((v(tri)>v(dutyA)+WEDGE)?0:(v(dutyA)+WEDGE-v(tri))/(2*WEDGE))) : 0) }
BglA glA 0 V={ ((v(fault)<1.5 && v(core5)>4.5) ? 10*v(arm)*((v(tri)<v(dutyA)+DTDU-WEDGE)?0:((v(tri)>v(dutyA)+DTDU+WEDGE)?1:(v(tri)-v(dutyA)-DTDU+WEDGE)/(2*WEDGE))) : 0) }
BchHA bus_inv swA I={v(bus_inv,swA)*((((v(ghA)<0)?0:((v(ghA)>10)?10:v(ghA)))/10)/RDSON+(1-((v(ghA)<0)?0:((v(ghA)>10)?10:v(ghA)))/10)/1Meg)}
BchLA swA nsA I={v(swA,nsA)*((((v(glA)<0)?0:((v(glA)>10)?10:v(glA)))/10)/RDSON+(1-((v(glA)<0)?0:((v(glA)>10)?10:v(glA)))/10)/1Meg)}
Bdha swA bus_inv I={(v(swA,bus_inv)>0.7)?(v(swA,bus_inv)-0.7)/20m:0}
Bdla nsA swA I={(v(nsA,swA)>0.7)?(v(nsA,swA)-0.7)/20m:0}
CossHA bus_inv swA 2.3e-09 IC=16.2
CossLA swA nsA 2.3e-09 IC=16.2
RshA nsA 0 {RSH}

* Phase B half bridge and low-side shunt.
BghB ghB 0 V={ ((v(fault)<1.5 && v(core5)>4.5) ? 10*v(arm)*((v(tri)<v(dutyB)-WEDGE)?1:((v(tri)>v(dutyB)+WEDGE)?0:(v(dutyB)+WEDGE-v(tri))/(2*WEDGE))) : 0) }
BglB glB 0 V={ ((v(fault)<1.5 && v(core5)>4.5) ? 10*v(arm)*((v(tri)<v(dutyB)+DTDU-WEDGE)?0:((v(tri)>v(dutyB)+DTDU+WEDGE)?1:(v(tri)-v(dutyB)-DTDU+WEDGE)/(2*WEDGE))) : 0) }
BchHB bus_inv swB I={v(bus_inv,swB)*((((v(ghB)<0)?0:((v(ghB)>10)?10:v(ghB)))/10)/RDSON+(1-((v(ghB)<0)?0:((v(ghB)>10)?10:v(ghB)))/10)/1Meg)}
BchLB swB nsB I={v(swB,nsB)*((((v(glB)<0)?0:((v(glB)>10)?10:v(glB)))/10)/RDSON+(1-((v(glB)<0)?0:((v(glB)>10)?10:v(glB)))/10)/1Meg)}
BdhB swB bus_inv I={(v(swB,bus_inv)>0.7)?(v(swB,bus_inv)-0.7)/20m:0}
BdlB nsB swB I={(v(nsB,swB)>0.7)?(v(nsB,swB)-0.7)/20m:0}
CossHB bus_inv swB 2.3e-09 IC=27.3111111111
CossLB swB nsB 2.3e-09 IC=5.08888888889
RshB nsB 0 {RSH}

* Phase C half bridge and low-side shunt.
BghC ghC 0 V={ ((v(fault)<1.5 && v(core5)>4.5) ? 10*v(arm)*((v(tri)<v(dutyC)-WEDGE)?1:((v(tri)>v(dutyC)+WEDGE)?0:(v(dutyC)+WEDGE-v(tri))/(2*WEDGE))) : 0) }
BglC glC 0 V={ ((v(fault)<1.5 && v(core5)>4.5) ? 10*v(arm)*((v(tri)<v(dutyC)+DTDU-WEDGE)?0:((v(tri)>v(dutyC)+DTDU+WEDGE)?1:(v(tri)-v(dutyC)-DTDU+WEDGE)/(2*WEDGE))) : 0) }
BchHC bus_inv swC I={v(bus_inv,swC)*((((v(ghC)<0)?0:((v(ghC)>10)?10:v(ghC)))/10)/RDSON+(1-((v(ghC)<0)?0:((v(ghC)>10)?10:v(ghC)))/10)/1Meg)}
BchLC swC nsC I={v(swC,nsC)*((((v(glC)<0)?0:((v(glC)>10)?10:v(glC)))/10)/RDSON+(1-((v(glC)<0)?0:((v(glC)>10)?10:v(glC)))/10)/1Meg)}
BdhC swC bus_inv I={(v(swC,bus_inv)>0.7)?(v(swC,bus_inv)-0.7)/20m:0}
BdlC nsC swC I={(v(nsC,swC)>0.7)?(v(nsC,swC)-0.7)/20m:0}
CossHC bus_inv swC 2.3e-09 IC=5.08888888889
CossLC swC nsC 2.3e-09 IC=27.3111111111
RshC nsC 0 {RSH}

* Three-phase star-connected motor model with sinusoidal back-EMF.
VsenseA swA phA 0
RphA phA phaL {RPH}
LphA phaL emA {LPH}
BemfA emA nstar V={EPK*sin(v(theta))}
VsenseB swB phB 0
RphB phB phbL {RPH}
LphB phbL emB {LPH}
BemfB emB nstar V={EPK*sin(v(theta)-2*pi/3)}
VsenseC swC phC 0
RphC phC phcL {RPH}
LphC phcL emC {LPH}
BemfC emC nstar V={EPK*sin(v(theta)+2*pi/3)}

* Use explicit transient initial conditions so the bus starts at VDC even
* though it is separated from Cbulk by the modeled link ESL.
.ic V(bus)={VDC} V(cap_i)={VDC} V(hfA_cap)={VDC} V(hfB_cap)={VDC} V(hfC_cap)={VDC} V(fault)=0 V(busov_n)=4.92017398333 V(ov_ref)=2.52409975893 V(ov_sense)=1.88372093023 V(shA_f)=0 V(shB_f)=0 V(shC_f)=0 V(nstar)=16.2 V(swA)=16.2 V(swB)=5.08888888889 V(swC)=27.3111111111 V(phA)=16.2 V(phaL)=16.2 V(emA)=16.2 V(phB)=5.08888888889 V(phbL)=5.08888888889 V(emB)=5.08888888889 V(phC)=27.3111111111 V(phcL)=27.3111111111 V(emC)=27.3111111111 V(bus_ff)={VDC}
.save V(bus) V(bus_inv) V(batt) V(cap_i) V(hfA_cap) V(dump_bus) V(bus_tvs) V(nstar) V(busov_n) V(ov_sense) V(ov_ref) V(brkgate) V(fault) V(swA) V(swB) V(swC) V(nsA) V(nsB) V(nsC) V(ghA) V(glA) V(ghB) V(glB) V(ghC) V(glC) V(shA_f) V(shB_f) V(shC_f) I(Vsense) I(Vtvs_sense) I(VsenseA) I(VsenseB) I(VsenseC) I(Vbus_sense) I(Llink) I(LhfA)

.control
set noaskquit
set numdgt=8
set filetype=binary

tran 2e-08 0.0022 0 2e-08 uic
let pac = v(swA,nstar)*i(VsenseA) + v(swB,nstar)*i(VsenseB) + v(swC,nstar)*i(VsenseC)
let pbus = v(bus)*i(Vbus_sense)
let psource = v(batt)*i(Vsense)
let iphase_abs = max(abs(i(VsenseA)),max(abs(i(VsenseB)),abs(i(VsenseC))))
let pdump = 2*v(bus,dump_bus)*v(bus,dump_bus)/2
let ptvs = v(bus)*i(Vtvs_sense)
let pmoss = (v(bus_inv,swA)*v(bus_inv,swA))*(v(ghA)/10/0.005+(1-v(ghA)/10)/1Meg)+(v(swA,nsA)*v(swA,nsA))*(v(glA)/10/0.005+(1-v(glA)/10)/1Meg)+(v(bus_inv,swB)*v(bus_inv,swB))*(v(ghB)/10/0.005+(1-v(ghB)/10)/1Meg)+(v(swB,nsB)*v(swB,nsB))*(v(glB)/10/0.005+(1-v(glB)/10)/1Meg)+(v(bus_inv,swC)*v(bus_inv,swC))*(v(ghC)/10/0.005+(1-v(ghC)/10)/1Meg)+(v(swC,nsC)*v(swC,nsC))*(v(glC)/10/0.005+(1-v(glC)/10)/1Meg)
meas tran pac_avg avg pac from=0.00035 to=0.00185
meas tran pac_energy integ pac from=0.0002 to=0.002
meas tran pbus_avg avg pbus from=0.00035 to=0.00185
meas tran pbus_energy integ pbus from=0.0002 to=0.002
meas tran psource_energy integ psource from=0.0002 to=0.002
meas tran dump_energy integ pdump from=0.0002 to=0.002
meas tran pmoss_avg avg pmoss from=0.00035 to=0.00185
meas tran pmoss_energy integ pmoss from=0.0002 to=0.002
meas tran tvs_current_peak max i(Vtvs_sense) from=0 to=0.0022
meas tran tvs_power_peak max ptvs from=0 to=0.0022
meas tran tvs_energy integ ptvs from=0 to=0.0022
meas tran vbus_max max v(bus) from=0 to=0.0022
meas tran vbus_min min v(bus) from=0 to=0.0022
meas tran busov_n_min min v(busov_n) from=0 to=0.0022
meas tran dump_gate_max max v(brkgate) from=0 to=0.0022
meas tran t_end max time from=0 to=0.0022
meas tran ia_max max i(VsenseA) from=0 to=0.0022
meas tran ia_min min i(VsenseA) from=0 to=0.0022
meas tran ib_max max i(VsenseB) from=0 to=0.0022
meas tran ib_min min i(VsenseB) from=0 to=0.0022
meas tran ic_max max i(VsenseC) from=0 to=0.0022
meas tran ic_min min i(VsenseC) from=0 to=0.0022
meas tran isource_max max i(Vsense) from=0 to=0.0022
meas tran isource_min min i(Vsense) from=0 to=0.0022
meas tran ibus_max max i(Vbus_sense) from=0 to=0.0022
meas tran ibus_min min i(Vbus_sense) from=0 to=0.0022
meas tran icap_rms rms i(Llink) from=0.0002 to=0.002
meas tran icap_max max i(Llink) from=0 to=0.0022
meas tran icap_min min i(Llink) from=0 to=0.0022
meas tran fault_latched max v(fault) from=0 to=0.0022
let vds_hi_max = max(v(bus_inv,swA),max(v(bus_inv,swB),v(bus_inv,swC)))
let vds_low_max = max(abs(v(swA,nsA)),max(abs(v(swB,nsB)),abs(v(swC,nsC))))
let vds_any_max = max(abs(v(bus_inv,swA)),max(abs(v(bus_inv,swB)),max(abs(v(bus_inv,swC)),vds_low_max)))
meas tran vds_hi_peak max vds_hi_max from=0 to=0.0022
meas tran vds_any_peak max vds_any_max from=0 to=0.0022
meas tran vds_startup_peak max vds_any_max from=0 to=0.000202
meas tran vds_postarm_peak max vds_any_max from=0.000202 to=0.0022
meas tran vbus_startup_max max v(bus) from=0 to=0.000202
meas tran vbus_postarm_max max v(bus) from=0.000202 to=0.0022
meas tran i_phase_startup_peak max iphase_abs from=0 to=0.000202
meas tran i_phase_postarm_peak max iphase_abs from=0.000202 to=0.0022
write switch_filtered_nodump_summary.raw V(bus) V(cap_i) V(hfA_cap) V(busov_n) V(ov_sense) V(ov_ref) V(brkgate) V(fault) V(swA) V(swB) V(swC) V(ghA) V(glA) V(ghB) V(glB) V(ghC) V(glC) V(shA_f) V(shB_f) V(shC_f) I(VsenseA) I(VsenseB) I(VsenseC) I(Llink) I(LhfA) I(Vtvs_sense)

quit
.endc
.end
