* Simplified LTC output (not ADI macro) + two HYG parameterized one-port gate-charge models.
* Drains and common source fixed at 0V: gate charging only, NO switching power circuit.
.include hyg.lib
Icp 0 bst 15u
Cbst bst 0 500n IC=10
Rleak bst 0 1G
Supper bst up ctl 0 SUP
Rturn up gate 10k
Sdown gate 0 ctlneg 0 SDN
Rgs gate 0 1Meg
Xpair 0 0 gate 0 HYG022_B2B
Vctl ctl 0 PULSE(0 3.3 10u 1n 1n 1.99m 5m)
Bneg ctlneg 0 V={3.3-v(ctl)}
.model SUP SW(Ron=7 Roff=1e12 Vt=1.65 Vh=0)
.model SDN SW(Ron=4 Roff=1e12 Vt=1.65 Vh=0)
.control
set noaskquit
tran 100n 3m 0 100n uic
wrdata combined_gate.txt v(ctl) v(gate) v(bst)
quit
.endc
.end
